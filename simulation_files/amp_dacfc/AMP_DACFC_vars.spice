.param W_M0=1
.param L_M0=1
.param M_M0=4
.param W_M5=1
.param L_M5=1
.param M_M5=4
.param W_M7=1
.param L_M7=1
.param M_M7=4
.param W_M8=1
.param L_M8=1
.param M_M8=4
.param W_M10=1
.param L_M10=1
.param M_M10=4
.param W_M11=1
.param L_M11=1
.param M_M11=4
.param W_M17=1
.param L_M17=1
.param M_M17=4
.param W_M21=1
.param L_M21=1
.param M_M21=4
.param W_M23=1
.param L_M23=1
.param M_M23=4
.param W_M58=1
.param L_M58=1
.param M_M58=4
.param I_Ib=5e-06
.param M_C0=1
.param M_C2=1
