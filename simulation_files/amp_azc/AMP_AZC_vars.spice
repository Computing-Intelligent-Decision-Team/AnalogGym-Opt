.param W_M0=1
.param L_M0=1
.param M_M0=4
.param W_M6=1
.param L_M6=1
.param M_M6=4
.param W_M9=1
.param L_M9=1
.param M_M9=4
.param W_M11=1
.param L_M11=1
.param M_M11=4
.param W_M12=1
.param L_M12=1
.param M_M12=4
.param W_M13=1
.param L_M13=1
.param M_M13=4
.param W_M14=1
.param L_M14=1
.param M_M14=4
.param W_M18=1
.param L_M18=1
.param M_M18=4
.param W_M19=1
.param L_M19=1
.param M_M19=4
.param W_M24=1
.param L_M24=1
.param M_M24=4
.param I_Ib=1e-06
.param M_C0=1
.param M_C1=1
.param M_C2=1
.param M_R0=4
.param M_R1=4
.param M_R2=4
.param M_R3=4
