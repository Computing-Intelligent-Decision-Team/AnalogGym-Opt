.param W_M0=1
.param L_M0=1
.param M_M0=4
.param W_M8=1
.param L_M8=0.35
.param M_M8=3
.param W_M10=1
.param L_M10=0.35
.param M_M10=24
.param W_M11=1
.param L_M11=0.35
.param M_M11=9
.param W_M17=1
.param L_M17=0.35
.param M_M17=2
.param W_M23=1
.param L_M23=0.35
.param M_M23=3
.param W_M66=1
.param L_M66=1
.param M_M66=16
.param W_M68=1
.param L_M68=0.35
.param M_M68=3
.param W_M70=1
.param L_M70=0.35
.param M_M70=3
.param I_Ib=1.25e-06
.param M_C0=12
.param M_C1=12
.param M_R0=4
