.param W_M0=1
.param L_M0=1
.param M_M0=200
.param W_M5=1
.param L_M5=1
.param M_M5=117
.param W_M8=1
.param L_M8=1
.param M_M8=100
.param W_M17=0.42
.param L_M17=1
.param M_M17=1
.param W_M68=1
.param L_M68=0.5
.param M_M68=6
.param W_M69=1
.param L_M69=0.9
.param M_M69=3
.param W_M70=1
.param L_M70=0.48
.param M_M70=2
.param W_M71=0.42
.param L_M71=1
.param M_M71=1
.param I_Ib=6.3e-07
.param M_C0=1
.param M_C1=1
.param M_R0=4
