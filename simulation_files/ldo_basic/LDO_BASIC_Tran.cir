Test LDO Tran

*.OPTIONS RELTOL=.0001
***************************************
* Step 1: Replace circuit netlist here.
***************************************
.include ./LDO_BASIC_netlist.txt

.param mc_mm_switch=0
.param mc_pr_switch=0
*.temp
.include ../sky130_pdk/libs.tech/ngspice/corners/tt.spice
.include ../sky130_pdk/libs.tech/ngspice/r+c/res_typical__cap_typical.spice
.include ../sky130_pdk/libs.tech/ngspice/r+c/res_typical__cap_typical__lin.spice
.include ../sky130_pdk/libs.tech/ngspice/corners/tt/specialized_cells.spice

***************************************
* Step 2: Replace circuit param.  here.
***************************************
.PARAM supply_voltage = 1.8
.PARAM Vref = 0.4
.PARAM PARAM_ILOAD = 55m
.PARAM val0 = 5m
.PARAM val1 = 55m
.PARAM GBW_ideal = 5e4
.PARAM STEP_TIME = '10/GBW_ideal'
.include ./LDO_BASIC_vars.spice

V1 vdd 0 'supply_voltage'
V2 vss 0 0

Vindc vref_in 0 'Vref'

* XLDO gnda vdda vinn vout vfb vinp Ib

*   Tran TB (load current step 5m -> 55m -> 5m)
x1 vss vdd vref_in vout1 vfb1 vfb1 Ib Basic_LDO
Ib Ib 0 DC='I_Ib'
XCL vout1 0 sky130_fd_pr__cap_mim_m3_1 W=30 L=30 MF=M_CL m=M_CL
Iload1 vout1 0 pulse('val0' 'val1' 1u 1u 1u '0.25*STEP_TIME' 1)

.control
save all
.options savecurrents
set filetype=ascii
set units=degrees

tran 10n 100u
meas tran v_min MIN v(vout1) from=0 to= 50u
meas tran v_max MAX v(vout1) from=50u to= 100u
let v_undershoot = 4*0.4 - v_min
let v_overshoot = v_max - 4*0.4
print v_undershoot
print v_overshoot
wrdata LDO_BASIC_Tran_meas v_undershoot v_overshoot

* OP
op
.include ./LDO_BASIC_dev_params.spice
.endc

.end
