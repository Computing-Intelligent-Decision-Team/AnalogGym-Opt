.param W_M0=0.7
.param L_M0=1.3
.param M_M0=48
.param W_M9=8.2
.param L_M9=0.6
.param M_M9=19
.param W_M11=1.3
.param L_M11=1.8
.param M_M11=47
.param W_M12=3.4000000000000004
.param L_M12=0.6
.param M_M12=131
.param W_M17=3.1
.param L_M17=0.5
.param M_M17=2
.param W_M18=0.9
.param L_M18=4.300000000000001
.param M_M18=1
.param W_M22=2.3
.param L_M22=2.4000000000000004
.param M_M22=5
.param W_M24=2.1
.param L_M24=3.9000000000000004
.param M_M24=1
.param W_M25=4.8
.param L_M25=0.5
.param M_M25=28
.param I_Ib=5.206958740949631e-06
.param M_C0=3
.param M_C1=6
