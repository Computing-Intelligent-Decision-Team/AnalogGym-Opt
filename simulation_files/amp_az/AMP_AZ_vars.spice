.param W_M0=1
.param L_M0=1
.param M_M0=4
.param W_M9=1
.param L_M9=1
.param M_M9=4
.param W_M11=1
.param L_M11=1
.param M_M11=4
.param W_M13=1
.param L_M13=1
.param M_M13=4
.param W_M14=1
.param L_M14=1
.param M_M14=4
.param W_M16=1
.param L_M16=1
.param M_M16=4
.param W_M18=1
.param L_M18=1
.param M_M18=4
.param W_M19=1
.param L_M19=1
.param M_M19=4
.param W_M22=1
.param L_M22=1
.param M_M22=4
.param W_M23=1
.param L_M23=1
.param M_M23=4
.param I_Ib=2e-05
.param M_C0=1
.param M_C1=1
.param M_R0=4
.param M_R1=4
.param M_R2=4
