.param W_M0=1.0
.param L_M0=1.0
.param M_M0=4
.param W_M8=1.0
.param L_M8=1.0
.param M_M8=4
.param W_M10=1.0
.param L_M10=1.0
.param M_M10=4
.param W_M11=1.0
.param L_M11=1.0
.param M_M11=4
.param W_M12=1.0
.param L_M12=1.0
.param M_M12=4
.param W_M18=1.0
.param L_M18=1.0
.param M_M18=4
.param W_M23=1.0
.param L_M23=1.0
.param M_M23=4
.param W_M25=1.0
.param L_M25=1.0
.param M_M25=4
.param I_Ib=1e-05
.param M_C0=10
.param M_C1=10
